* netlist for cell BUF
.subckt BUF A Y
* device stubs for BUF
.ends BUF
