* netlist for cell NAND2
.subckt NAND2 A B Y
* device stubs for NAND2
.ends NAND2
