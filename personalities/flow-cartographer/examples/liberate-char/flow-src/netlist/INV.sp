* netlist for cell INV
.subckt INV A Y
* device stubs for INV
.ends INV
